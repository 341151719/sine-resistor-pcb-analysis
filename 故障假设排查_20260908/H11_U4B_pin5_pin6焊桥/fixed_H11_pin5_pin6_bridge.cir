* H11: adjacent U4B non-inverting/inverting input solder bridge.
* U4P is U4 pin 5 (MUL_RAW), U4N is U4 pin 6 (U4B_N).
* Only this one connection is added; U4 output pin 7 remains VCMD/U4O.
.param R16VAL=39k
.include "fault_fixed_common.inc"
RBRIDGE_U4P_U4N U4P U4N 1m
.control
set noaskquit
echo "CASE H11 nearest adjacent pin5-pin6 bridge, R16=39k, J1=+/-5, J2=+/-10, OPA548 OFF"
tran 0.05u 0.5m 0 0.05u
meas tran TP8_MAX MAX v(TP8) from=0.25m to=0.5m
meas tran TP8_MIN MIN v(TP8) from=0.25m to=0.5m
meas tran OUT_MAX MAX v(OPA_OUT) from=0.25m to=0.5m
meas tran OUT_MIN MIN v(OPA_OUT) from=0.25m to=0.5m
meas tran TP8_EARLY_MAX MAX v(TP8) from=10u to=0.25m
meas tran TP8_EARLY_MIN MIN v(TP8) from=10u to=0.25m
meas tran U4O_MAX MAX v(U4O) from=0.25m to=0.5m
meas tran U4O_MIN MIN v(U4O) from=0.25m to=0.5m
meas tran IP_FINAL FIND i(VJ1P) AT=0.5m
meas tran IN_FINAL FIND i(VJ1N) AT=0.5m
meas tran I2P_FINAL FIND i(VJ2P) AT=0.5m
meas tran I2N_FINAL FIND i(VJ2N) AT=0.5m
let TP8_PP=TP8_MAX-TP8_MIN
let OUT_PP=OUT_MAX-OUT_MIN
let U4O_PP=U4O_MAX-U4O_MIN
echo "RESULT H11"
print TP8_PP OUT_PP U4O_PP TP8_EARLY_MAX TP8_EARLY_MIN IP_FINAL IN_FINAL I2P_FINAL I2N_FINAL
wrdata results/fixed_H11_pin5_pin6_bridge.dat time v(TP8) v(U4O) v(OPA_OUT) v(ES) v(VPLUS) v(VMINUS) i(VJ1P) i(VJ1N) i(VJ2P) i(VJ2N)
quit
.endc
.end
