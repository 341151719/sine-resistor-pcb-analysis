* H06: single assembly/value fault at C39 (VCMD--U4B_N feedback capacitor).
* Official TI OPA1656 + OPA548 models; J2=+/-10 V, J1=+/-5 V, E/S OFF.
* No periodic source: one 1 mV / 2 us startup kick only.
.include "/mnt/c/Users/Administrator/Documents/稳定性原因分析CODEX/实际遇到的问题/opa548_shutdown_branch_spice_20260904/models/OPA548.LIB"
.include "/mnt/c/Users/Administrator/Documents/稳定性原因分析CODEX/实际遇到的问题/opa548_shutdown_branch_spice_20260904/models/OPA1656.LIB"
.param TEMP=27 R5OHM=100 C39VAL=0.05p
.options method=gear reltol=2e-4 abstol=1e-11 vntol=1e-8 gmin=1e-12 rshunt=1e12 maxord=2

* Board supply rails for the official-model control (J2 and J1 fixed).
VJ2P U4PLUS 0 10
VJ2N U4MINUS 0 -10
VJ1P VPLUS 0 5
VJ1N VMINUS 0 -5
VES ES VMINUS 0.6

* U4B stimulus and the unused OPA1656 channel's real load.
VINPUT SRC 0 PULSE(0 1m 10u 20n 20n 2u 1)
RIN SRC U4P 100
CIN U4P 0 2p
VUA U4AP 0 0
R13 U4AN 0 1k
R14 U4AO U4AN 49.9k
XU4A U4AP U4AN U4PLUS U4MINUS U4AO OPA1656
RU4AL U4AO 0 100k

* U4B feedback copper and populated R16/R15.
ROR16 U4O OR16M 5.380m
LOR16 OR16M R16O 4.1652n
COR16A U4O 0 0.3471p
COR16B R16O 0 0.3471p
RNR16 U4N NR16M 5.780m
LNR16 NR16M R16N 4.4694n
CNR16A U4N 0 0.37245p
CNR16B R16N 0 0.37245p
RNR15 U4N NR15M 6.723m
LNR15 NR15M R15N 5.6334n
CNR15A U4N 0 0.46945p
CNR15B R15N 0 0.46945p
R16 R16O R16N 39k
R15 R15N 0 1k
CDNP14 R16O R16N 0.05p
CDNP37 R16O R16N 0.05p
CDNP38 R16O R16N 0.05p
CC39 R16O R16N {C39VAL}
CDNP40 R16O R16N 0.05p
CDNP41 R16O R16N 0.05p
XU4 U4P U4N U4PLUS U4MINUS U4O OPA1656

* TP8 is before populated R5; OPA548 is the official OFF macro.
RTP8 U4O TP8 1m
RTP8P TP8 0 10Meg
R5 TP8 OPA_P {R5OHM}
RUNIT OPA_OUT OPA_N 1m
RILIM ILIM VMINUS 57.6k
XU1 OPA_P OPA_N ILIM VMINUS VPLUS OPA_OUT ES OPA548
RLOAD OPA_OUT SNUB 4.7
CLOAD SNUB 0 47n
RLEAK SNUB 0 1G

.control
set noaskquit
echo "H06 C39 sensitivity; J2=+/-10, J1=+/-5, E/S OFF; late=0.25--0.5 ms"
foreach c39v 0.05p 22p 220p
  alterparam C39VAL=$c39v
  reset
  tran 0.05u 0.5m 0 0.05u
  meas tran TP8_MAX MAX v(TP8) from=0.25m to=0.5m
  meas tran TP8_MIN MIN v(TP8) from=0.25m to=0.5m
  meas tran OUT_MAX MAX v(OPA_OUT) from=0.25m to=0.5m
  meas tran OUT_MIN MIN v(OPA_OUT) from=0.25m to=0.5m
  meas tran TP8_EARLY_MAX MAX v(TP8) from=10u to=0.25m
  meas tran TP8_EARLY_MIN MIN v(TP8) from=10u to=0.25m
  meas tran TP8_FINAL FIND v(TP8) AT=0.5m
  meas tran U4O_FINAL FIND v(U4O) AT=0.5m
  let TP8_PP=TP8_MAX-TP8_MIN
  let OUT_PP=OUT_MAX-OUT_MIN
  echo "CASE C39=$c39v"
  print TP8_PP OUT_PP TP8_EARLY_MAX TP8_EARLY_MIN TP8_FINAL U4O_FINAL
  wrdata results/H06_C39_last_case.dat time v(TP8) v(U4O) v(OPA_OUT) v(OPA_P) v(OPA_N)
end
quit
.endc
.end
