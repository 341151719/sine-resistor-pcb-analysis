* PCB_AWARE_full_extracted_loop.cir
* Direct segmented-copper extraction reference model.
* NOTE: OPA548 vendor macro is retained here for AC loading only; do not use
* its shutdown transient as a calibrated OFF-state truth model.
.include "models/OPA1656.LIB"
.include "models/OPA548.LIB"
.include "models/AD633.cir"
.options method=gear reltol=2e-4 abstol=1e-11 vntol=1e-8 gmin=1e-12
R_ANA_P_1 ANA_P_N0 ANA_P_M0 0.00159213048
L_ANA_P_1 ANA_P_M0 ANA_P_N1 0.7389n
R_ANA_P_2 ANA_P_N2 ANA_P_M1 0.00448453318
L_ANA_P_2 ANA_P_M1 ANA_P_N3 5.55n
R_ANA_P_3 ANA_P_N4 ANA_P_M2 0.000453786277
L_ANA_P_3 ANA_P_M2 ANA_P_N5 0.351n
R_ANA_P_4 ANA_P_N5 ANA_P_M3 0.00178428637
L_ANA_P_4 ANA_P_M3 ANA_P_N6 1.38013102n
R_ANA_P_5 ANA_P_N7 ANA_P_M4 0.000719455565
L_ANA_P_5 ANA_P_M4 ANA_P_N8 0.333895822n
R_ANA_P_6 ANA_P_N9 ANA_P_M5 0.00314030446
L_ANA_P_6 ANA_P_M5 ANA_P_N10 1.4574n
R_ANA_P_7 ANA_P_N11 ANA_P_M6 0.00165467154
L_ANA_P_7 ANA_P_M6 ANA_P_N12 2.0478n
R_ANA_P_8 ANA_P_N3 ANA_P_M7 0.00123264061
L_ANA_P_8 ANA_P_M7 ANA_P_N13 1.5255n
R_ANA_P_9 ANA_P_N14 ANA_P_M8 0.00145444319
L_ANA_P_9 ANA_P_M8 ANA_P_N15 1.125n
R_ANA_P_10 ANA_P_N16 ANA_P_M9 0.00148805699
L_ANA_P_10 ANA_P_M9 ANA_P_N11 1.3812n
R_ANA_P_11 ANA_P_N17 ANA_P_M10 0.000840344957
L_ANA_P_11 ANA_P_M10 ANA_P_N18 0.78n
R_ANA_P_12 ANA_P_N1 ANA_P_M11 0.00119910761
L_ANA_P_12 ANA_P_M11 ANA_P_N19 0.5565n
R_ANA_P_13 ANA_P_N19 ANA_P_M12 0.0011317484
L_ANA_P_13 ANA_P_M12 ANA_P_N9 0.525238917n
R_ANA_P_14 ANA_P_N20 ANA_P_M13 0.00184850034
L_ANA_P_14 ANA_P_M13 ANA_P_N21 1.4298n
R_ANA_P_15 ANA_P_N22 ANA_P_M14 0.00186491658
L_ANA_P_15 ANA_P_M14 ANA_P_N2 2.30799653n
R_ANA_P_16 ANA_P_N23 ANA_P_M15 0.000559475816
L_ANA_P_16 ANA_P_M15 ANA_P_N22 0.6924n
R_ANA_P_17 ANA_P_N10 ANA_P_M16 1.75521561e-05
L_ANA_P_17 ANA_P_M16 ANA_P_N24 0.0135764502n
R_ANA_P_18 ANA_P_N25 ANA_P_M17 0.000886628571
L_ANA_P_18 ANA_P_M17 ANA_P_N26 0.6858n
R_ANA_P_19 ANA_P_N15 ANA_P_M18 0.00153252263
L_ANA_P_19 ANA_P_M18 ANA_P_N27 1.18539381n
R_ANA_P_20 ANA_P_N13 ANA_P_M19 0.00121528112
L_ANA_P_20 ANA_P_M19 ANA_P_N28 1.50401612n
R_ANA_P_21 ANA_P_N28 ANA_P_M20 0.00268127468
L_ANA_P_21 ANA_P_M20 ANA_P_N29 1.24436651n
R_ANA_P_22 ANA_P_N24 ANA_P_M21 0.00462862002
L_ANA_P_22 ANA_P_M21 ANA_P_N30 3.5802n
R_ANA_P_23 ANA_P_N31 ANA_P_M22 0.00157435396
L_ANA_P_23 ANA_P_M22 ANA_P_N32 1.4613n
R_ANA_P_24 ANA_P_N12 ANA_P_M23 1.09700976e-05
L_ANA_P_24 ANA_P_M23 ANA_P_N33 0.0135764502n
R_ANA_P_25 ANA_P_N21 ANA_P_M24 0.000139320239
L_ANA_P_25 ANA_P_M24 ANA_P_N31 0.107763073n
R_ANA_P_26 ANA_P_N6 ANA_P_M25 0.00290384432
L_ANA_P_26 ANA_P_M25 ANA_P_N34 2.2461n
R_ANA_P_27 ANA_P_N18 ANA_P_M26 0.00116100199
L_ANA_P_27 ANA_P_M26 ANA_P_N16 1.07763073n
R_ANA_P_28 ANA_P_N29 ANA_P_M27 0.0109942977
L_ANA_P_28 ANA_P_M27 ANA_P_N7 5.1024n
R_ANA_P_29 ANA_P_N26 ANA_P_M28 0.000835921434
L_ANA_P_29 ANA_P_M28 ANA_P_N35 0.646578441n
R_ANA_P_30 ANA_P_N36 ANA_P_M29 0.00185760319
L_ANA_P_30 ANA_P_M29 ANA_P_N0 0.862104588n
R_ANA_P_31 ANA_P_N37 ANA_P_M30 0.00464400796
L_ANA_P_31 ANA_P_M30 ANA_P_N38 2.15526147n
R_ANA_P_32 ANA_P_N39 ANA_P_M31 0.000696601195
L_ANA_P_32 ANA_P_M31 ANA_P_N40 0.862104588n
R_ANA_P_33 ANA_P_N41 ANA_P_M32 0.00189416985
L_ANA_P_33 ANA_P_M32 ANA_P_N39 2.3442n
R_ANA_P_34 ANA_P_N1 ANA_P_M33 0.00366196475
L_ANA_P_34 ANA_P_M33 ANA_P_N37 1.6995n
R_ANA_P_35 ANA_P_N35 ANA_P_M34 0.00729005714
L_ANA_P_35 ANA_P_M34 ANA_P_N27 5.6388n
R_ANA_P_36 ANA_P_N42 ANA_P_M35 0.00699451429
L_ANA_P_36 ANA_P_M35 ANA_P_N35 5.4102n
R_ANA_P_37 ANA_P_N43 ANA_P_M36 0.00574695986
L_ANA_P_37 ANA_P_M36 ANA_P_N33 7.11236285n
R_ANA_P_38 ANA_P_N38 ANA_P_M37 0.00295542857
L_ANA_P_38 ANA_P_M37 ANA_P_N31 1.3716n
R_ANA_P_39 ANA_P_N8 ANA_P_M38 0.000928801593
L_ANA_P_39 ANA_P_M38 ANA_P_N44 0.431052294n
R_ANA_P_40 ANA_P_N40 ANA_P_M39 0.0102208571
L_ANA_P_40 ANA_P_M39 ANA_P_N43 12.6492n
R_ANA_P_41 ANA_P_N44 ANA_P_M40 0.00967107762
L_ANA_P_41 ANA_P_M40 ANA_P_N36 4.4883n
R_ANA_P_42 ANA_P_N31 ANA_P_M41 0.00236844406
L_ANA_P_42 ANA_P_M41 ANA_P_N42 1.83197225n
RPAD_ANA_P_C11_1_0 ANA_P_PAD_C11_1 ANA_P_N28 1m
RPAD_ANA_P_C11_1_1 ANA_P_PAD_C11_1 ANA_P_N29 1m
RPAD_ANA_P_U2_6_0 ANA_P_PAD_U2_6 ANA_P_N17 1m
RPAD_ANA_P_U2_6_1 ANA_P_PAD_U2_6 ANA_P_N18 1m
RPAD_ANA_P_U2_6_2 ANA_P_PAD_U2_6 ANA_P_N30 1m
RPAD_ANA_P_U3_7_0 ANA_P_PAD_U3_7 ANA_P_N14 1m
RPAD_ANA_P_U3_7_1 ANA_P_PAD_U3_7 ANA_P_N15 1m
RPAD_ANA_P_C15_1_0 ANA_P_PAD_C15_1 ANA_P_N10 1m
RPAD_ANA_P_C15_1_1 ANA_P_PAD_C15_1 ANA_P_N24 1m
RPAD_ANA_P_U8_8_0 ANA_P_PAD_U8_8 ANA_P_N25 1m
RPAD_ANA_P_U8_8_1 ANA_P_PAD_U8_8 ANA_P_N26 1m
RPAD_ANA_P_U8_8_2 ANA_P_PAD_U8_8 ANA_P_N35 1m
RPAD_ANA_P_U4_8_0 ANA_P_PAD_U4_8 ANA_P_N20 1m
RPAD_ANA_P_FB1_2_0 ANA_P_PAD_FB1_2 ANA_P_N32 1m
RPAD_ANA_P_U10_4_0 ANA_P_PAD_U10_4 ANA_P_N4 1m
RPAD_ANA_P_U10_4_1 ANA_P_PAD_U10_4 ANA_P_N5 1m
RPAD_ANA_P_C9_1_0 ANA_P_PAD_C9_1 ANA_P_N11 1m
RPAD_ANA_P_TP11_1_0 ANA_P_PAD_TP11_1 ANA_P_N22 1m
RPAD_ANA_P_TP11_1_1 ANA_P_PAD_TP11_1 ANA_P_N23 1m
RPAD_ANA_P_J6_3_0 ANA_P_PAD_J6_3 ANA_P_N3 1m
RPAD_ANA_P_U9_8_0 ANA_P_PAD_U9_8 ANA_P_N41 1m
RG_ANA_P_0 ANA_P_N0 0 1e12
RG_ANA_P_1 ANA_P_N1 0 1e12
RG_ANA_P_2 ANA_P_N2 0 1e12
RG_ANA_P_3 ANA_P_N3 0 1e12
RG_ANA_P_4 ANA_P_N4 0 1e12
RG_ANA_P_5 ANA_P_N5 0 1e12
RG_ANA_P_6 ANA_P_N6 0 1e12
RG_ANA_P_7 ANA_P_N7 0 1e12
RG_ANA_P_8 ANA_P_N8 0 1e12
RG_ANA_P_9 ANA_P_N9 0 1e12
RG_ANA_P_10 ANA_P_N10 0 1e12
RG_ANA_P_11 ANA_P_N11 0 1e12
RG_ANA_P_12 ANA_P_N12 0 1e12
RG_ANA_P_13 ANA_P_N13 0 1e12
RG_ANA_P_14 ANA_P_N14 0 1e12
RG_ANA_P_15 ANA_P_N15 0 1e12
RG_ANA_P_16 ANA_P_N16 0 1e12
RG_ANA_P_17 ANA_P_N17 0 1e12
RG_ANA_P_18 ANA_P_N18 0 1e12
RG_ANA_P_19 ANA_P_N19 0 1e12
RG_ANA_P_20 ANA_P_N20 0 1e12
RG_ANA_P_21 ANA_P_N21 0 1e12
RG_ANA_P_22 ANA_P_N22 0 1e12
RG_ANA_P_23 ANA_P_N23 0 1e12
RG_ANA_P_24 ANA_P_N24 0 1e12
RG_ANA_P_25 ANA_P_N25 0 1e12
RG_ANA_P_26 ANA_P_N26 0 1e12
RG_ANA_P_27 ANA_P_N27 0 1e12
RG_ANA_P_28 ANA_P_N28 0 1e12
RG_ANA_P_29 ANA_P_N29 0 1e12
RG_ANA_P_30 ANA_P_N30 0 1e12
RG_ANA_P_31 ANA_P_N31 0 1e12
RG_ANA_P_32 ANA_P_N32 0 1e12
RG_ANA_P_33 ANA_P_N33 0 1e12
RG_ANA_P_34 ANA_P_N34 0 1e12
RG_ANA_P_35 ANA_P_N35 0 1e12
RG_ANA_P_36 ANA_P_N36 0 1e12
RG_ANA_P_37 ANA_P_N37 0 1e12
RG_ANA_P_38 ANA_P_N38 0 1e12
RG_ANA_P_39 ANA_P_N39 0 1e12
RG_ANA_P_40 ANA_P_N40 0 1e12
RG_ANA_P_41 ANA_P_N41 0 1e12
RG_ANA_P_42 ANA_P_N42 0 1e12
RG_ANA_P_43 ANA_P_N43 0 1e12
RG_ANA_P_44 ANA_P_N44 0 1e12
R_ANA_N_1 ANA_N_N0 ANA_N_M0 8.41040813e-05
L_ANA_N_1 ANA_N_M0 ANA_N_N1 0.0390322943n
R_ANA_N_2 ANA_N_N2 ANA_N_M1 0.00268975028
L_ANA_N_2 ANA_N_M1 ANA_N_N3 1.2483n
R_ANA_N_3 ANA_N_N4 ANA_N_M2 0.00255420438
L_ANA_N_3 ANA_N_M2 ANA_N_N5 2.37078762n
R_ANA_N_4 ANA_N_N6 ANA_N_M3 0.00188806119
L_ANA_N_4 ANA_N_M3 ANA_N_N7 1.4604n
R_ANA_N_5 ANA_N_N8 ANA_N_M4 0.0020055802
L_ANA_N_5 ANA_N_M4 ANA_N_N6 1.5513n
R_ANA_N_6 ANA_N_N9 ANA_N_M5 0.00233525399
L_ANA_N_6 ANA_N_M5 ANA_N_N10 1.8063n
R_ANA_N_7 ANA_N_N11 ANA_N_M6 0.00203298838
L_ANA_N_7 ANA_N_M6 ANA_N_N12 1.887n
R_ANA_N_8 ANA_N_N13 ANA_N_M7 0.00251105533
L_ANA_N_8 ANA_N_M7 ANA_N_N14 1.94228091n
R_ANA_N_9 ANA_N_N15 ANA_N_M8 0.00181116311
L_ANA_N_9 ANA_N_M8 ANA_N_N16 1.40091995n
R_ANA_N_10 ANA_N_N17 ANA_N_M9 0.00324502437
L_ANA_N_10 ANA_N_M9 ANA_N_N18 1.506n
R_ANA_N_11 ANA_N_N3 ANA_N_M10 6.21638861e-05
L_ANA_N_11 ANA_N_M10 ANA_N_N19 0.0288499567n
R_ANA_N_12 ANA_N_N16 ANA_N_M11 0.00679748571
L_ANA_N_12 ANA_N_M11 ANA_N_N20 5.2578n
R_ANA_N_13 ANA_N_N21 ANA_N_M12 0.00236434286
L_ANA_N_13 ANA_N_M12 ANA_N_N15 1.8288n
R_ANA_N_14 ANA_N_N1 ANA_N_M13 3.65669918e-05
L_ANA_N_14 ANA_N_M13 ANA_N_N22 0.0169705627n
R_ANA_N_15 ANA_N_N23 ANA_N_M14 0.00301860518
L_ANA_N_15 ANA_N_M14 ANA_N_N24 2.80183991n
R_ANA_N_16 ANA_N_N7 ANA_N_M15 0.00100815197
L_ANA_N_16 ANA_N_M15 ANA_N_N25 0.779797358n
R_ANA_N_17 ANA_N_N18 ANA_N_M16 0.00262510836
L_ANA_N_17 ANA_N_M16 ANA_N_N0 1.2183n
R_ANA_N_18 ANA_N_N26 ANA_N_M17 0.00303752381
L_ANA_N_18 ANA_N_M17 ANA_N_N23 2.8194n
R_ANA_N_19 ANA_N_N27 ANA_N_M18 0.000982040045
L_ANA_N_19 ANA_N_M18 ANA_N_N28 0.7596n
R_ANA_N_20 ANA_N_N14 ANA_N_M19 9.61871766e-05
L_ANA_N_20 ANA_N_M19 ANA_N_N29 0.0744n
R_ANA_N_21 ANA_N_N28 ANA_N_M20 0.00269644998
L_ANA_N_21 ANA_N_M20 ANA_N_N21 2.08568216n
R_ANA_N_22 ANA_N_N19 ANA_N_M21 0.00011312336
L_ANA_N_22 ANA_N_M21 ANA_N_N4 0.105n
R_ANA_N_23 ANA_N_N30 ANA_N_M22 0.00176472441
L_ANA_N_23 ANA_N_M22 ANA_N_N13 1.365n
R_ANA_N_24 ANA_N_N20 ANA_N_M23 0.00648277915
L_ANA_N_24 ANA_N_M23 ANA_N_N9 5.01437703n
R_ANA_N_25 ANA_N_N2 ANA_N_M24 0.0028688084
L_ANA_N_25 ANA_N_M24 ANA_N_N1 1.3314n
R_ANA_N_26 ANA_N_N31 ANA_N_M25 0.00766261314
L_ANA_N_26 ANA_N_M25 ANA_N_N32 3.55618142n
R_ANA_N_27 ANA_N_N10 ANA_N_M26 0.00875994976
L_ANA_N_27 ANA_N_M26 ANA_N_N33 8.1309n
R_ANA_N_28 ANA_N_N12 ANA_N_M27 0.00508990476
L_ANA_N_28 ANA_N_M27 ANA_N_N34 4.7244n
R_ANA_N_29 ANA_N_N35 ANA_N_M28 0.00533619048
L_ANA_N_29 ANA_N_M28 ANA_N_N34 4.953n
R_ANA_N_30 ANA_N_N34 ANA_N_M29 0.00299895042
L_ANA_N_30 ANA_N_M29 ANA_N_N36 2.78359655n
R_ANA_N_31 ANA_N_N33 ANA_N_M30 0.00101747655
L_ANA_N_31 ANA_N_M30 ANA_N_N5 0.944411817n
R_ANA_N_32 ANA_N_N36 ANA_N_M31 0.00912646944
L_ANA_N_32 ANA_N_M31 ANA_N_N6 8.4711n
R_ANA_N_33 ANA_N_N32 ANA_N_M32 0.00361219048
L_ANA_N_33 ANA_N_M32 ANA_N_N18 1.6764n
R_ANA_N_34 ANA_N_N6 ANA_N_M33 0.00939731909
L_ANA_N_34 ANA_N_M33 ANA_N_N37 8.7225n
R_ANA_N_35 ANA_N_N38 ANA_N_M34 0.00217810949
L_ANA_N_35 ANA_N_M34 ANA_N_N10 2.0217n
R_ANA_N_36 ANA_N_N24 ANA_N_M35 0.00592111016
L_ANA_N_36 ANA_N_M35 ANA_N_N35 5.49591675n
R_ANA_N_37 ANA_N_N37 ANA_N_M36 0.00299895042
L_ANA_N_37 ANA_N_M36 ANA_N_N29 2.78359655n
R_ANA_N_38 ANA_N_N12 ANA_N_M37 0.0177325714
L_ANA_N_38 ANA_N_M37 ANA_N_N31 8.2296n
RPAD_ANA_N_U2_3_0 ANA_N_PAD_U2_3 ANA_N_N17 1m
RPAD_ANA_N_C12_1_0 ANA_N_PAD_C12_1 ANA_N_N2 1m
RPAD_ANA_N_C12_1_1 ANA_N_PAD_C12_1 ANA_N_N3 1m
RPAD_ANA_N_C12_1_2 ANA_N_PAD_C12_1 ANA_N_N4 1m
RPAD_ANA_N_C12_1_3 ANA_N_PAD_C12_1 ANA_N_N19 1m
RPAD_ANA_N_U3_4_0 ANA_N_PAD_U3_4 ANA_N_N30 1m
RPAD_ANA_N_C16_1_0 ANA_N_PAD_C16_1 ANA_N_N0 1m
RPAD_ANA_N_C16_1_1 ANA_N_PAD_C16_1 ANA_N_N1 1m
RPAD_ANA_N_C16_1_2 ANA_N_PAD_C16_1 ANA_N_N2 1m
RPAD_ANA_N_C16_1_3 ANA_N_PAD_C16_1 ANA_N_N18 1m
RPAD_ANA_N_C16_1_4 ANA_N_PAD_C16_1 ANA_N_N22 1m
RPAD_ANA_N_U8_4_0 ANA_N_PAD_U8_4 ANA_N_N8 1m
RPAD_ANA_N_C10_1_0 ANA_N_PAD_C10_1 ANA_N_N0 1m
RPAD_ANA_N_C10_1_1 ANA_N_PAD_C10_1 ANA_N_N1 1m
RPAD_ANA_N_C10_1_2 ANA_N_PAD_C10_1 ANA_N_N2 1m
RPAD_ANA_N_C10_1_3 ANA_N_PAD_C10_1 ANA_N_N3 1m
RPAD_ANA_N_C10_1_4 ANA_N_PAD_C10_1 ANA_N_N4 1m
RPAD_ANA_N_C10_1_5 ANA_N_PAD_C10_1 ANA_N_N19 1m
RPAD_ANA_N_C10_1_6 ANA_N_PAD_C10_1 ANA_N_N22 1m
RPAD_ANA_N_C10_1_7 ANA_N_PAD_C10_1 ANA_N_N32 1m
RPAD_ANA_N_U4_4_0 ANA_N_PAD_U4_4 ANA_N_N11 1m
RPAD_ANA_N_U10_7_0 ANA_N_PAD_U10_7 ANA_N_N27 1m
RPAD_ANA_N_U10_7_1 ANA_N_PAD_U10_7 ANA_N_N28 1m
RPAD_ANA_N_FB2_2_0 ANA_N_PAD_FB2_2 ANA_N_N7 1m
RPAD_ANA_N_FB2_2_1 ANA_N_PAD_FB2_2 ANA_N_N25 1m
RPAD_ANA_N_TP12_1_0 ANA_N_PAD_TP12_1 ANA_N_N26 1m
RPAD_ANA_N_U9_4_0 ANA_N_PAD_U9_4 ANA_N_N38 1m
RG_ANA_N_0 ANA_N_N0 0 1e12
RG_ANA_N_1 ANA_N_N1 0 1e12
RG_ANA_N_2 ANA_N_N2 0 1e12
RG_ANA_N_3 ANA_N_N3 0 1e12
RG_ANA_N_4 ANA_N_N4 0 1e12
RG_ANA_N_5 ANA_N_N5 0 1e12
RG_ANA_N_6 ANA_N_N6 0 1e12
RG_ANA_N_7 ANA_N_N7 0 1e12
RG_ANA_N_8 ANA_N_N8 0 1e12
RG_ANA_N_9 ANA_N_N9 0 1e12
RG_ANA_N_10 ANA_N_N10 0 1e12
RG_ANA_N_11 ANA_N_N11 0 1e12
RG_ANA_N_12 ANA_N_N12 0 1e12
RG_ANA_N_13 ANA_N_N13 0 1e12
RG_ANA_N_14 ANA_N_N14 0 1e12
RG_ANA_N_15 ANA_N_N15 0 1e12
RG_ANA_N_16 ANA_N_N16 0 1e12
RG_ANA_N_17 ANA_N_N17 0 1e12
RG_ANA_N_18 ANA_N_N18 0 1e12
RG_ANA_N_19 ANA_N_N19 0 1e12
RG_ANA_N_20 ANA_N_N20 0 1e12
RG_ANA_N_21 ANA_N_N21 0 1e12
RG_ANA_N_22 ANA_N_N22 0 1e12
RG_ANA_N_23 ANA_N_N23 0 1e12
RG_ANA_N_24 ANA_N_N24 0 1e12
RG_ANA_N_25 ANA_N_N25 0 1e12
RG_ANA_N_26 ANA_N_N26 0 1e12
RG_ANA_N_27 ANA_N_N27 0 1e12
RG_ANA_N_28 ANA_N_N28 0 1e12
RG_ANA_N_29 ANA_N_N29 0 1e12
RG_ANA_N_30 ANA_N_N30 0 1e12
RG_ANA_N_31 ANA_N_N31 0 1e12
RG_ANA_N_32 ANA_N_N32 0 1e12
RG_ANA_N_33 ANA_N_N33 0 1e12
RG_ANA_N_34 ANA_N_N34 0 1e12
RG_ANA_N_35 ANA_N_N35 0 1e12
RG_ANA_N_36 ANA_N_N36 0 1e12
RG_ANA_N_37 ANA_N_N37 0 1e12
RG_ANA_N_38 ANA_N_N38 0 1e12
R_MUL_RAW_1 MUL_RAW_N0 MUL_RAW_M0 0.00220105737
L_MUL_RAW_1 MUL_RAW_M0 MUL_RAW_N1 1.0215n
C_MUL_RAW_1a MUL_RAW_N0 0 0.085125p
C_MUL_RAW_1b MUL_RAW_N1 0 0.085125p
R_MUL_RAW_2 MUL_RAW_N2 MUL_RAW_M1 0.00595933858
L_MUL_RAW_2 MUL_RAW_M1 MUL_RAW_N3 2.7657n
C_MUL_RAW_2a MUL_RAW_N2 0 0.230475p
C_MUL_RAW_2b MUL_RAW_N3 0 0.230475p
R_MUL_RAW_3 MUL_RAW_N4 MUL_RAW_M2 0.0290565429
L_MUL_RAW_3 MUL_RAW_M2 MUL_RAW_N5 13.485n
C_MUL_RAW_3a MUL_RAW_N4 0 1.12375p
C_MUL_RAW_3b MUL_RAW_N5 0 1.12375p
R_MUL_RAW_4 MUL_RAW_N6 MUL_RAW_M3 5.48504878e-05
L_MUL_RAW_4 MUL_RAW_M3 MUL_RAW_N7 0.0254558441n
C_MUL_RAW_4a MUL_RAW_N6 0 0.00212132034p
C_MUL_RAW_4b MUL_RAW_N7 0 0.00212132034p
R_MUL_RAW_5 MUL_RAW_N7 MUL_RAW_M4 0.0110208009
L_MUL_RAW_5 MUL_RAW_M4 MUL_RAW_N0 5.1147n
C_MUL_RAW_5a MUL_RAW_N7 0 0.426225p
C_MUL_RAW_5b MUL_RAW_N0 0 0.426225p
R_MUL_RAW_6 MUL_RAW_N8 MUL_RAW_M5 0.00105172403
L_MUL_RAW_6 MUL_RAW_M5 MUL_RAW_N9 0.4881n
C_MUL_RAW_6a MUL_RAW_N8 0 0.040675p
C_MUL_RAW_6b MUL_RAW_N9 0 0.040675p
R_MUL_RAW_7 MUL_RAW_N5 MUL_RAW_M6 0.000928801593
L_MUL_RAW_7 MUL_RAW_M6 MUL_RAW_N2 0.431052294n
C_MUL_RAW_7a MUL_RAW_N5 0 0.0359210245p
C_MUL_RAW_7b MUL_RAW_N2 0 0.0359210245p
R_MUL_RAW_8 MUL_RAW_N9 MUL_RAW_M7 0.000331845451
L_MUL_RAW_8 MUL_RAW_M7 MUL_RAW_N4 0.154007857n
C_MUL_RAW_8a MUL_RAW_N9 0 0.0128339881p
C_MUL_RAW_8b MUL_RAW_N4 0 0.0128339881p
R_MUL_RAW_9 MUL_RAW_N8 MUL_RAW_M8 0.00254042745
L_MUL_RAW_9 MUL_RAW_M8 MUL_RAW_N10 1.179n
C_MUL_RAW_9a MUL_RAW_N8 0 0.09825p
C_MUL_RAW_9b MUL_RAW_N10 0 0.09825p
R_MUL_RAW_10 MUL_RAW_N11 MUL_RAW_M9 0.00355336633
L_MUL_RAW_10 MUL_RAW_M9 MUL_RAW_N0 1.6491n
C_MUL_RAW_10a MUL_RAW_N11 0 0.137425p
C_MUL_RAW_10b MUL_RAW_N0 0 0.137425p
R_MUL_RAW_11 MUL_RAW_N10 MUL_RAW_M10 0.00102844665
L_MUL_RAW_11 MUL_RAW_M10 MUL_RAW_N11 0.477297077n
C_MUL_RAW_11a MUL_RAW_N10 0 0.0397747564p
C_MUL_RAW_11b MUL_RAW_N11 0 0.0397747564p
RPAD_MUL_RAW_U2_5_0 MUL_RAW_PAD_U2_5 MUL_RAW_N0 1m
RPAD_MUL_RAW_U2_5_1 MUL_RAW_PAD_U2_5 MUL_RAW_N1 1m
RPAD_MUL_RAW_U2_5_2 MUL_RAW_PAD_U2_5 MUL_RAW_N10 1m
RPAD_MUL_RAW_U2_5_3 MUL_RAW_PAD_U2_5 MUL_RAW_N11 1m
RPAD_MUL_RAW_U4_5_0 MUL_RAW_PAD_U4_5 MUL_RAW_N6 1m
RPAD_MUL_RAW_U4_5_1 MUL_RAW_PAD_U4_5 MUL_RAW_N7 1m
RPAD_MUL_RAW_TP7_1_0 MUL_RAW_PAD_TP7_1 MUL_RAW_N3 1m
RG_MUL_RAW_0 MUL_RAW_N0 0 1e12
RG_MUL_RAW_1 MUL_RAW_N1 0 1e12
RG_MUL_RAW_2 MUL_RAW_N2 0 1e12
RG_MUL_RAW_3 MUL_RAW_N3 0 1e12
RG_MUL_RAW_4 MUL_RAW_N4 0 1e12
RG_MUL_RAW_5 MUL_RAW_N5 0 1e12
RG_MUL_RAW_6 MUL_RAW_N6 0 1e12
RG_MUL_RAW_7 MUL_RAW_N7 0 1e12
RG_MUL_RAW_8 MUL_RAW_N8 0 1e12
RG_MUL_RAW_9 MUL_RAW_N9 0 1e12
RG_MUL_RAW_10 MUL_RAW_N10 0 1e12
RG_MUL_RAW_11 MUL_RAW_N11 0 1e12
R_U4B_N_1 U4B_N_N0 U4B_N_M0 0.00933674961
L_U4B_N_1 U4B_N_M0 U4B_N_N1 7.2219n
C_U4B_N_1a U4B_N_N0 0 0.601825p
C_U4B_N_1b U4B_N_N1 0 0.601825p
R_U4B_N_2 U4B_N_N2 U4B_N_M1 0.0111173759
L_U4B_N_2 U4B_N_M1 U4B_N_N3 8.5992n
C_U4B_N_2a U4B_N_N2 0 0.7166p
C_U4B_N_2b U4B_N_N3 0 0.7166p
R_U4B_N_3 U4B_N_N4 U4B_N_M2 0.00153252263
L_U4B_N_3 U4B_N_M2 U4B_N_N5 1.18539381n
C_U4B_N_3a U4B_N_N4 0 0.0987828173p
C_U4B_N_3b U4B_N_N5 0 0.0987828173p
R_U4B_N_4 U4B_N_N6 U4B_N_M3 0.000909026997
L_U4B_N_4 U4B_N_M3 U4B_N_N7 1.125n
C_U4B_N_4a U4B_N_N6 0 0.09375p
C_U4B_N_4b U4B_N_N7 0 0.09375p
R_U4B_N_5 U4B_N_N7 U4B_N_M4 3.15390305e-05
L_U4B_N_5 U4B_N_M4 U4B_N_N8 0.0390322943n
C_U4B_N_5a U4B_N_N7 0 0.00325269119p
C_U4B_N_5b U4B_N_N8 0 0.00325269119p
R_U4B_N_6 U4B_N_N9 U4B_N_M5 0.000961871766
L_U4B_N_6 U4B_N_M5 U4B_N_N4 0.744n
C_U4B_N_6a U4B_N_N9 0 0.062p
C_U4B_N_6b U4B_N_N4 0 0.062p
R_U4B_N_7 U4B_N_N5 U4B_N_M6 0.000775703037
L_U4B_N_7 U4B_N_M6 U4B_N_N10 0.6n
C_U4B_N_7a U4B_N_N5 0 0.05p
C_U4B_N_7b U4B_N_N10 0 0.05p
R_U4B_N_8 U4B_N_N11 U4B_N_M7 0.000370786052
L_U4B_N_8 U4B_N_M7 U4B_N_N9 0.2868n
C_U4B_N_8a U4B_N_N11 0 0.0239p
C_U4B_N_8b U4B_N_N9 0 0.0239p
R_U4B_N_9 U4B_N_N1 U4B_N_M8 0.00773062775
L_U4B_N_9 U4B_N_M8 U4B_N_N12 5.97957778n
C_U4B_N_9a U4B_N_N1 0 0.498298149p
C_U4B_N_9b U4B_N_N12 0 0.498298149p
R_U4B_N_10 U4B_N_N10 U4B_N_M9 0.0025077643
L_U4B_N_10 U4B_N_M9 U4B_N_N6 1.93973532n
C_U4B_N_10a U4B_N_N10 0 0.16164461p
C_U4B_N_10b U4B_N_N6 0 0.16164461p
R_U4B_N_11 U4B_N_N12 U4B_N_M10 0.00251095073
L_U4B_N_11 U4B_N_M10 U4B_N_N2 1.9422n
C_U4B_N_11a U4B_N_N12 0 0.16185p
C_U4B_N_11b U4B_N_N2 0 0.16185p
R_U4B_N_12 U4B_N_N3 U4B_N_M11 0.00267121875
L_U4B_N_12 U4B_N_M11 U4B_N_N11 2.06616601n
C_U4B_N_12a U4B_N_N3 0 0.172180501p
C_U4B_N_12b U4B_N_N11 0 0.172180501p
R_U4B_N_13 U4B_N_N13 U4B_N_M12 0.00132645219
L_U4B_N_13 U4B_N_M12 U4B_N_N14 1.6416n
C_U4B_N_13a U4B_N_N13 0 0.1368p
C_U4B_N_13b U4B_N_N14 0 0.1368p
R_U4B_N_14 U4B_N_N15 U4B_N_M13 0.00322886389
L_U4B_N_14 U4B_N_M13 U4B_N_N16 2.4975n
C_U4B_N_14a U4B_N_N15 0 0.208125p
C_U4B_N_14b U4B_N_N16 0 0.208125p
R_U4B_N_15 U4B_N_N16 U4B_N_M14 0.00479338413
L_U4B_N_15 U4B_N_M14 U4B_N_N2 3.7076437n
C_U4B_N_15a U4B_N_N16 0 0.308970308p
C_U4B_N_15b U4B_N_N2 0 0.308970308p
R_U4B_N_16 U4B_N_N17 U4B_N_M15 0.00132620979
L_U4B_N_16 U4B_N_M15 U4B_N_N18 1.6413n
C_U4B_N_16a U4B_N_N17 0 0.136775p
C_U4B_N_16b U4B_N_N18 0 0.136775p
R_U4B_N_17 U4B_N_N19 U4B_N_M16 0.00132645219
L_U4B_N_17 U4B_N_M16 U4B_N_N13 1.6416n
C_U4B_N_17a U4B_N_N19 0 0.1368p
C_U4B_N_17b U4B_N_N13 0 0.1368p
R_U4B_N_18 U4B_N_N18 U4B_N_M17 0.00132645219
L_U4B_N_18 U4B_N_M17 U4B_N_N19 1.6416n
C_U4B_N_18a U4B_N_N18 0 0.1368p
C_U4B_N_18b U4B_N_N19 0 0.1368p
R_U4B_N_19 U4B_N_N14 U4B_N_M18 0.00132620979
L_U4B_N_19 U4B_N_M18 U4B_N_N15 1.6413n
C_U4B_N_19a U4B_N_N14 0 0.136775p
C_U4B_N_19b U4B_N_N15 0 0.136775p
RPAD_U4B_N_R16_2_0 U4B_N_PAD_R16_2 U4B_N_N6 1m
RPAD_U4B_N_R16_2_1 U4B_N_PAD_R16_2 U4B_N_N7 1m
RPAD_U4B_N_R16_2_2 U4B_N_PAD_R16_2 U4B_N_N8 1m
RPAD_U4B_N_U4_6_0 U4B_N_PAD_U4_6 U4B_N_N4 1m
RPAD_U4B_N_U4_6_1 U4B_N_PAD_U4_6 U4B_N_N9 1m
RPAD_U4B_N_U4_6_2 U4B_N_PAD_U4_6 U4B_N_N11 1m
RPAD_U4B_N_C14_2_0 U4B_N_PAD_C14_2 U4B_N_N0 1m
RPAD_U4B_N_R15_1_0 U4B_N_PAD_R15_1 U4B_N_N6 1m
RPAD_U4B_N_R15_1_1 U4B_N_PAD_R15_1 U4B_N_N7 1m
RPAD_U4B_N_R15_1_2 U4B_N_PAD_R15_1 U4B_N_N8 1m
RPAD_U4B_N_C38_2_0 U4B_N_PAD_C38_2 U4B_N_N18 1m
RPAD_U4B_N_C41_2_0 U4B_N_PAD_C41_2 U4B_N_N14 1m
RPAD_U4B_N_C42_2_0 U4B_N_PAD_C42_2 U4B_N_N15 1m
RPAD_U4B_N_C40_2_0 U4B_N_PAD_C40_2 U4B_N_N13 1m
RPAD_U4B_N_C39_2_0 U4B_N_PAD_C39_2 U4B_N_N19 1m
RPAD_U4B_N_C37_2_0 U4B_N_PAD_C37_2 U4B_N_N17 1m
RG_U4B_N_0 U4B_N_N0 0 1e12
RG_U4B_N_1 U4B_N_N1 0 1e12
RG_U4B_N_2 U4B_N_N2 0 1e12
RG_U4B_N_3 U4B_N_N3 0 1e12
RG_U4B_N_4 U4B_N_N4 0 1e12
RG_U4B_N_5 U4B_N_N5 0 1e12
RG_U4B_N_6 U4B_N_N6 0 1e12
RG_U4B_N_7 U4B_N_N7 0 1e12
RG_U4B_N_8 U4B_N_N8 0 1e12
RG_U4B_N_9 U4B_N_N9 0 1e12
RG_U4B_N_10 U4B_N_N10 0 1e12
RG_U4B_N_11 U4B_N_N11 0 1e12
RG_U4B_N_12 U4B_N_N12 0 1e12
RG_U4B_N_13 U4B_N_N13 0 1e12
RG_U4B_N_14 U4B_N_N14 0 1e12
RG_U4B_N_15 U4B_N_N15 0 1e12
RG_U4B_N_16 U4B_N_N16 0 1e12
RG_U4B_N_17 U4B_N_N17 0 1e12
RG_U4B_N_18 U4B_N_N18 0 1e12
RG_U4B_N_19 U4B_N_N19 0 1e12
R_VCMD_1 VCMD_N0 VCMD_M0 0.00362232621
L_VCMD_1 VCMD_M0 VCMD_N1 2.80183991n
C_VCMD_1a VCMD_N0 0 0.233486659p
C_VCMD_1b VCMD_N1 0 0.233486659p
R_VCMD_2 VCMD_N2 VCMD_M1 0.00126430374
L_VCMD_2 VCMD_M1 VCMD_N3 0.977928678n
C_VCMD_2a VCMD_N2 0 0.0814940565p
C_VCMD_2b VCMD_N3 0 0.0814940565p
R_VCMD_3 VCMD_N4 VCMD_M2 0.00857054893
L_VCMD_3 VCMD_M2 VCMD_N5 10.6068n
C_VCMD_3a VCMD_N4 0 0.8839p
C_VCMD_3b VCMD_N5 0 0.8839p
R_VCMD_4 VCMD_N6 VCMD_M3 0.000750354673
L_VCMD_4 VCMD_M3 VCMD_N7 0.580393246n
C_VCMD_4a VCMD_N6 0 0.0483661038p
C_VCMD_4b VCMD_N7 0 0.0483661038p
R_VCMD_5 VCMD_N8 VCMD_M4 0.000329285939
L_VCMD_5 VCMD_M4 VCMD_N9 0.2547n
C_VCMD_5a VCMD_N8 0 0.021225p
C_VCMD_5b VCMD_N9 0 0.021225p
R_VCMD_6 VCMD_N10 VCMD_M5 0.000368183899
L_VCMD_6 VCMD_M5 VCMD_N11 0.45565961n
C_VCMD_6a VCMD_N10 0 0.0379716341p
C_VCMD_6b VCMD_N11 0 0.0379716341p
R_VCMD_7 VCMD_N12 VCMD_M6 0.00632535825
L_VCMD_7 VCMD_M6 VCMD_N13 4.89261324n
C_VCMD_7a VCMD_N12 0 0.40771777p
C_VCMD_7b VCMD_N13 0 0.40771777p
R_VCMD_8 VCMD_N13 VCMD_M7 0.00994994286
L_VCMD_8 VCMD_M7 VCMD_N6 7.6962n
C_VCMD_8a VCMD_N13 0 0.64135p
C_VCMD_8b VCMD_N6 0 0.64135p
R_VCMD_9 VCMD_N1 VCMD_M8 0.000504982677
L_VCMD_9 VCMD_M8 VCMD_N14 0.3906n
C_VCMD_9a VCMD_N1 0 0.03255p
C_VCMD_9b VCMD_N14 0 0.03255p
R_VCMD_10 VCMD_N3 VCMD_M9 0.00897061777
L_VCMD_10 VCMD_M9 VCMD_N15 6.9387n
C_VCMD_10a VCMD_N3 0 0.578225p
C_VCMD_10b VCMD_N15 0 0.578225p
R_VCMD_11 VCMD_N15 VCMD_M10 0.00438039505
L_VCMD_11 VCMD_M10 VCMD_N12 3.3882n
C_VCMD_11a VCMD_N15 0 0.28235p
C_VCMD_11b VCMD_N12 0 0.28235p
R_VCMD_12 VCMD_N11 VCMD_M11 0.00950357424
L_VCMD_12 VCMD_M11 VCMD_N16 11.7615n
C_VCMD_12a VCMD_N11 0 0.980125p
C_VCMD_12b VCMD_N16 0 0.980125p
R_VCMD_13 VCMD_N7 VCMD_M12 6.47712036e-05
L_VCMD_13 VCMD_M12 VCMD_N17 0.0501n
C_VCMD_13a VCMD_N7 0 0.004175p
C_VCMD_13b VCMD_N17 0 0.004175p
R_VCMD_14 VCMD_N5 VCMD_M13 8.22757317e-06
L_VCMD_14 VCMD_M13 VCMD_N10 0.0101823376n
C_VCMD_14a VCMD_N5 0 0.000848528137p
C_VCMD_14b VCMD_N10 0 0.000848528137p
R_VCMD_15 VCMD_N18 VCMD_M14 8.22757317e-06
L_VCMD_15 VCMD_M14 VCMD_N4 0.0101823376n
C_VCMD_15a VCMD_N18 0 0.000848528137p
C_VCMD_15b VCMD_N4 0 0.000848528137p
R_VCMD_16 VCMD_N19 VCMD_M15 0.000548034196
L_VCMD_16 VCMD_M15 VCMD_N2 0.4239n
C_VCMD_16a VCMD_N19 0 0.035325p
C_VCMD_16b VCMD_N2 0 0.035325p
R_VCMD_17 VCMD_N17 VCMD_M16 0.000784361975
L_VCMD_17 VCMD_M16 VCMD_N8 0.606697618n
C_VCMD_17a VCMD_N17 0 0.0505581349p
C_VCMD_17b VCMD_N8 0 0.0505581349p
R_VCMD_18 VCMD_N19 VCMD_M17 0.00125741462
L_VCMD_18 VCMD_M17 VCMD_N0 0.9726n
C_VCMD_18a VCMD_N19 0 0.08105p
C_VCMD_18b VCMD_N0 0 0.08105p
R_VCMD_19 VCMD_N20 VCMD_M18 0.00132645219
L_VCMD_19 VCMD_M18 VCMD_N21 1.6416n
C_VCMD_19a VCMD_N20 0 0.1368p
C_VCMD_19b VCMD_N21 0 0.1368p
R_VCMD_20 VCMD_N22 VCMD_M19 0.00132620979
L_VCMD_20 VCMD_M19 VCMD_N23 1.6413n
C_VCMD_20a VCMD_N22 0 0.136775p
C_VCMD_20b VCMD_N23 0 0.136775p
R_VCMD_21 VCMD_N24 VCMD_M20 0.0079048018
L_VCMD_21 VCMD_M20 VCMD_N15 6.1143n
C_VCMD_21a VCMD_N24 0 0.509525p
C_VCMD_21b VCMD_N15 0 0.509525p
R_VCMD_22 VCMD_N21 VCMD_M21 0.00132645219
L_VCMD_22 VCMD_M21 VCMD_N22 1.6416n
C_VCMD_22a VCMD_N21 0 0.1368p
C_VCMD_22b VCMD_N22 0 0.1368p
R_VCMD_23 VCMD_N25 VCMD_M22 0.00146316985
L_VCMD_23 VCMD_M22 VCMD_N26 1.8108n
C_VCMD_23a VCMD_N25 0 0.1509p
C_VCMD_23b VCMD_N26 0 0.1509p
R_VCMD_24 VCMD_N25 VCMD_M23 0.00151442197
L_VCMD_24 VCMD_M23 VCMD_N24 1.17139309n
C_VCMD_24a VCMD_N25 0 0.0976160911p
C_VCMD_24b VCMD_N24 0 0.0976160911p
R_VCMD_25 VCMD_N27 VCMD_M24 0.00132645219
L_VCMD_25 VCMD_M24 VCMD_N20 1.6416n
C_VCMD_25a VCMD_N27 0 0.1368p
C_VCMD_25b VCMD_N20 0 0.1368p
R_VCMD_26 VCMD_N26 VCMD_M25 0.000514737575
L_VCMD_26 VCMD_M25 VCMD_N27 0.637032534n
C_VCMD_26a VCMD_N26 0 0.0530860445p
C_VCMD_26b VCMD_N27 0 0.0530860445p
RPAD_VCMD_R5_1_0 VCMD_PAD_R5_1 VCMD_N5 1m
RPAD_VCMD_R5_1_1 VCMD_PAD_R5_1 VCMD_N10 1m
RPAD_VCMD_R5_1_2 VCMD_PAD_R5_1 VCMD_N11 1m
RPAD_VCMD_R16_1_0 VCMD_PAD_R16_1 VCMD_N1 1m
RPAD_VCMD_R16_1_1 VCMD_PAD_R16_1 VCMD_N14 1m
RPAD_VCMD_U4_7_0 VCMD_PAD_U4_7 VCMD_N0 1m
RPAD_VCMD_U4_7_1 VCMD_PAD_U4_7 VCMD_N2 1m
RPAD_VCMD_U4_7_2 VCMD_PAD_U4_7 VCMD_N3 1m
RPAD_VCMD_U4_7_3 VCMD_PAD_U4_7 VCMD_N19 1m
RPAD_VCMD_C14_1_0 VCMD_PAD_C14_1 VCMD_N7 1m
RPAD_VCMD_C14_1_1 VCMD_PAD_C14_1 VCMD_N8 1m
RPAD_VCMD_C14_1_2 VCMD_PAD_C14_1 VCMD_N9 1m
RPAD_VCMD_C14_1_3 VCMD_PAD_C14_1 VCMD_N16 1m
RPAD_VCMD_C14_1_4 VCMD_PAD_C14_1 VCMD_N17 1m
RPAD_VCMD_TP8_1_0 VCMD_PAD_TP8_1 VCMD_N4 1m
RPAD_VCMD_TP8_1_1 VCMD_PAD_TP8_1 VCMD_N18 1m
RPAD_VCMD_R45_1_0 VCMD_PAD_R45_1 VCMD_N24 1m
RPAD_VCMD_R45_1_1 VCMD_PAD_R45_1 VCMD_N25 1m
RPAD_VCMD_C38_1_0 VCMD_PAD_C38_1 VCMD_N22 1m
RPAD_VCMD_C41_1_0 VCMD_PAD_C41_1 VCMD_N27 1m
RPAD_VCMD_C40_1_0 VCMD_PAD_C40_1 VCMD_N20 1m
RPAD_VCMD_C39_1_0 VCMD_PAD_C39_1 VCMD_N21 1m
RPAD_VCMD_C37_1_0 VCMD_PAD_C37_1 VCMD_N23 1m
RG_VCMD_0 VCMD_N0 0 1e12
RG_VCMD_1 VCMD_N1 0 1e12
RG_VCMD_2 VCMD_N2 0 1e12
RG_VCMD_3 VCMD_N3 0 1e12
RG_VCMD_4 VCMD_N4 0 1e12
RG_VCMD_5 VCMD_N5 0 1e12
RG_VCMD_6 VCMD_N6 0 1e12
RG_VCMD_7 VCMD_N7 0 1e12
RG_VCMD_8 VCMD_N8 0 1e12
RG_VCMD_9 VCMD_N9 0 1e12
RG_VCMD_10 VCMD_N10 0 1e12
RG_VCMD_11 VCMD_N11 0 1e12
RG_VCMD_12 VCMD_N12 0 1e12
RG_VCMD_13 VCMD_N13 0 1e12
RG_VCMD_14 VCMD_N14 0 1e12
RG_VCMD_15 VCMD_N15 0 1e12
RG_VCMD_16 VCMD_N16 0 1e12
RG_VCMD_17 VCMD_N17 0 1e12
RG_VCMD_18 VCMD_N18 0 1e12
RG_VCMD_19 VCMD_N19 0 1e12
RG_VCMD_20 VCMD_N20 0 1e12
RG_VCMD_21 VCMD_N21 0 1e12
RG_VCMD_22 VCMD_N22 0 1e12
RG_VCMD_23 VCMD_N23 0 1e12
RG_VCMD_24 VCMD_N24 0 1e12
RG_VCMD_25 VCMD_N25 0 1e12
RG_VCMD_26 VCMD_N26 0 1e12
RG_VCMD_27 VCMD_N27 0 1e12
R_OPA_IN_P_1 OPA_IN_P_N0 OPA_IN_P_M0 0.00066956774
L_OPA_IN_P_1 OPA_IN_P_M0 OPA_IN_P_N1 0.725067293n
C_OPA_IN_P_1a OPA_IN_P_N0 0 0.0604222745p
C_OPA_IN_P_1b OPA_IN_P_N1 0 0.0604222745p
R_OPA_IN_P_2 OPA_IN_P_N2 OPA_IN_P_M1 0.00316182099
L_OPA_IN_P_2 OPA_IN_P_M1 OPA_IN_P_N0 3.4239n
C_OPA_IN_P_2a OPA_IN_P_N2 0 0.285325p
C_OPA_IN_P_2b OPA_IN_P_N0 0 0.285325p
RPAD_OPA_IN_P_R5_2_0 OPA_IN_P_PAD_R5_2 OPA_IN_P_N0 1m
RPAD_OPA_IN_P_R5_2_1 OPA_IN_P_PAD_R5_2 OPA_IN_P_N1 1m
RPAD_OPA_IN_P_U1_1_0 OPA_IN_P_PAD_U1_1 OPA_IN_P_N2 1m
RG_OPA_IN_P_0 OPA_IN_P_N0 0 1e12
RG_OPA_IN_P_1 OPA_IN_P_N1 0 1e12
RG_OPA_IN_P_2 OPA_IN_P_N2 0 1e12
R_OPA_IN_N_1 OPA_IN_N_N0 OPA_IN_N_M0 4.97572282e-05
L_OPA_IN_N_1 OPA_IN_N_M0 OPA_IN_N_N1 0.0538815367n
C_OPA_IN_N_1a OPA_IN_N_N0 0 0.00449012806p
C_OPA_IN_N_1b OPA_IN_N_N1 0 0.00449012806p
R_OPA_IN_N_2 OPA_IN_N_N2 OPA_IN_N_M1 0.00361228282
L_OPA_IN_N_2 OPA_IN_N_M1 OPA_IN_N_N0 3.9117n
C_OPA_IN_N_2a OPA_IN_N_N2 0 0.325975p
C_OPA_IN_N_2b OPA_IN_N_N0 0 0.325975p
RPAD_OPA_IN_N_U1_2_0 OPA_IN_N_PAD_U1_2 OPA_IN_N_N2 1m
RPAD_OPA_IN_N_R6_2_0 OPA_IN_N_PAD_R6_2 OPA_IN_N_N0 1m
RPAD_OPA_IN_N_R6_2_1 OPA_IN_N_PAD_R6_2 OPA_IN_N_N1 1m
RG_OPA_IN_N_0 OPA_IN_N_N0 0 1e12
RG_OPA_IN_N_1 OPA_IN_N_N1 0 1e12
RG_OPA_IN_N_2 OPA_IN_N_N2 0 1e12
R_OPA_OUT_1 OPA_OUT_N0 OPA_OUT_M0 0.00229874747
L_OPA_OUT_1 OPA_OUT_M0 OPA_OUT_N1 2.8449n
C_OPA_OUT_1a OPA_OUT_N0 0 0.237075p
C_OPA_OUT_1b OPA_OUT_N1 0 0.237075p
R_OPA_OUT_2 OPA_OUT_N1 OPA_OUT_M1 0.000927692351
L_OPA_OUT_2 OPA_OUT_M1 OPA_OUT_N2 1.1481n
C_OPA_OUT_2a OPA_OUT_N1 0 0.095675p
C_OPA_OUT_2b OPA_OUT_N2 0 0.095675p
RPAD_OPA_OUT_U1_6_0 OPA_OUT_PAD_U1_6 OPA_OUT_N0 1m
RPAD_OPA_OUT_R46_1_0 OPA_OUT_PAD_R46_1 OPA_OUT_N2 1m
RG_OPA_OUT_0 OPA_OUT_N0 0 1e12
RG_OPA_OUT_1 OPA_OUT_N1 0 1e12
RG_OPA_OUT_2 OPA_OUT_N2 0 1e12
R_DRV_1 DRV_N0 DRV_M0 0.00176583256
L_DRV_1 DRV_M0 DRV_N1 1.9122n
C_DRV_1a DRV_N0 0 0.15935p
C_DRV_1b DRV_N1 0 0.15935p
R_DRV_2 DRV_N2 DRV_M1 0.00131366918
L_DRV_2 DRV_M1 DRV_N0 1.42255742n
C_DRV_2a DRV_N2 0 0.118546452p
C_DRV_2b DRV_N0 0 0.118546452p
R_DRV_3 DRV_N3 DRV_M2 0.00150825759
L_DRV_3 DRV_M2 DRV_N4 1.8666n
C_DRV_3a DRV_N3 0 0.15555p
C_DRV_3b DRV_N4 0 0.15555p
R_DRV_4 DRV_N5 DRV_M3 0.00100562627
L_DRV_4 DRV_M3 DRV_N1 2.4891n
C_DRV_4a DRV_N5 0 0.207425p
C_DRV_4b DRV_N1 0 0.207425p
R_DRV_5 DRV_N5 DRV_M4 0.000707344207
L_DRV_5 DRV_M4 DRV_N6 1.7508n
C_DRV_5a DRV_N5 0 0.1459p
C_DRV_5b DRV_N6 0 0.1459p
R_DRV_6 DRV_N7 DRV_M5 0.0058287619
L_DRV_6 DRV_M5 DRV_N8 5.4102n
C_DRV_6a DRV_N7 0 0.45085p
C_DRV_6b DRV_N8 0 0.45085p
R_DRV_7 DRV_N8 DRV_M6 0.000928801593
L_DRV_7 DRV_M6 DRV_N9 0.862104588n
C_DRV_7a DRV_N8 0 0.071842049p
C_DRV_7b DRV_N9 0 0.071842049p
R_DRV_8 DRV_N10 DRV_M7 0.00338230765
L_DRV_8 DRV_M7 DRV_N11 4.1859n
C_DRV_8a DRV_N10 0 0.348825p
C_DRV_8b DRV_N11 0 0.348825p
R_DRV_9 DRV_N12 DRV_M8 0.00391838172
L_DRV_9 DRV_M8 DRV_N13 4.84933831n
C_DRV_9a DRV_N12 0 0.404111525p
C_DRV_9b DRV_N13 0 0.404111525p
R_DRV_10 DRV_N11 DRV_M9 0.00265169235
L_DRV_10 DRV_M9 DRV_N12 3.2817n
C_DRV_10a DRV_N11 0 0.273475p
C_DRV_10b DRV_N12 0 0.273475p
R_DRV_11 DRV_N14 DRV_M10 0.00139320239
L_DRV_11 DRV_M10 DRV_N11 1.72420918n
C_DRV_11a DRV_N14 0 0.143684098p
C_DRV_11b DRV_N11 0 0.143684098p
R_DRV_12 DRV_N15 DRV_M11 0.00193347969
L_DRV_12 DRV_M11 DRV_N10 2.39284935n
C_DRV_12a DRV_N15 0 0.199404112p
C_DRV_12b DRV_N10 0 0.199404112p
R_DRV_13 DRV_N2 DRV_M12 0.00157007143
L_DRV_13 DRV_M12 DRV_N15 1.9431n
C_DRV_13a DRV_N2 0 0.161925p
C_DRV_13b DRV_N15 0 0.161925p
RPAD_DRV_R12_1_0 DRV_PAD_R12_1 DRV_N3 1m
RPAD_DRV_TP2_1_0 DRV_PAD_TP2_1 DRV_N7 1m
RPAD_DRV_D1_2_0 DRV_PAD_D1_2 DRV_N1 1m
RPAD_DRV_RSH2_1_0 DRV_PAD_RSH2_1 DRV_N4 1m
RPAD_DRV_RSH2_1_1 DRV_PAD_RSH2_1 DRV_N6 1m
RPAD_DRV_D2_1_0 DRV_PAD_D2_1 DRV_N5 1m
RPAD_DRV_R46_2_0 DRV_PAD_R46_2 DRV_N14 1m
RG_DRV_0 DRV_N0 0 1e12
RG_DRV_1 DRV_N1 0 1e12
RG_DRV_2 DRV_N2 0 1e12
RG_DRV_3 DRV_N3 0 1e12
RG_DRV_4 DRV_N4 0 1e12
RG_DRV_5 DRV_N5 0 1e12
RG_DRV_6 DRV_N6 0 1e12
RG_DRV_7 DRV_N7 0 1e12
RG_DRV_8 DRV_N8 0 1e12
RG_DRV_9 DRV_N9 0 1e12
RG_DRV_10 DRV_N10 0 1e12
RG_DRV_11 DRV_N11 0 1e12
RG_DRV_12 DRV_N12 0 1e12
RG_DRV_13 DRV_N13 0 1e12
RG_DRV_14 DRV_N14 0 1e12
RG_DRV_15 DRV_N15 0 1e12
R_SPK_1 SPK_N0 SPK_M0 0.00105334008
L_SPK_1 SPK_M0 SPK_N1 0.9777n
C_SPK_1a SPK_N0 0 0.081475p
C_SPK_1b SPK_N1 0 0.081475p
R_SPK_2 SPK_N2 SPK_M1 0.00091351153
L_SPK_2 SPK_M1 SPK_N3 2.2611n
C_SPK_2a SPK_N2 0 0.188425p
C_SPK_2b SPK_N3 0 0.188425p
R_SPK_3 SPK_N4 SPK_M2 0.00501815223
L_SPK_3 SPK_M2 SPK_N5 4.6578n
C_SPK_3a SPK_N4 0 0.38815p
C_SPK_3b SPK_N5 0 0.38815p
R_SPK_4 SPK_N0 SPK_M3 0.002242509
L_SPK_4 SPK_M3 SPK_N6 5.5506n
C_SPK_4a SPK_N0 0 0.46255p
C_SPK_4b SPK_N6 0 0.46255p
R_SPK_5 SPK_N7 SPK_M4 0.006896
L_SPK_5 SPK_M4 SPK_N8 6.4008n
C_SPK_5a SPK_N7 0 0.5334p
C_SPK_5b SPK_N8 0 0.5334p
R_SPK_6 SPK_N1 SPK_M5 0.0119290669
L_SPK_6 SPK_M5 SPK_N7 11.0724437n
C_SPK_6a SPK_N1 0 0.922703639p
C_SPK_6b SPK_N7 0 0.922703639p
R_SPK_7 SPK_N9 SPK_M6 0.00100342729
L_SPK_7 SPK_M6 SPK_N10 1.0866n
C_SPK_7a SPK_N9 0 0.09055p
C_SPK_7b SPK_N10 0 0.09055p
R_SPK_8 SPK_N11 SPK_M7 0.000281469388
L_SPK_8 SPK_M7 SPK_N12 0.3048n
C_SPK_8a SPK_N11 0 0.0254p
C_SPK_8b SPK_N12 0 0.0254p
R_SPK_9 SPK_N13 SPK_M8 0.00142650447
L_SPK_9 SPK_M8 SPK_N14 1.54474547n
C_SPK_9a SPK_N13 0 0.12872879p
C_SPK_9b SPK_N14 0 0.12872879p
R_SPK_10 SPK_N14 SPK_M9 0.00310502844
L_SPK_10 SPK_M9 SPK_N15 3.3624n
C_SPK_10a SPK_N14 0 0.2802p
C_SPK_10b SPK_N15 0 0.2802p
R_SPK_11 SPK_N5 SPK_M10 0.000232200398
L_SPK_11 SPK_M10 SPK_N16 0.215526147n
C_SPK_11a SPK_N5 0 0.0179605122p
C_SPK_11b SPK_N16 0 0.0179605122p
R_SPK_12 SPK_N12 SPK_M11 0.00150682126
L_SPK_12 SPK_M11 SPK_N4 1.63171961n
C_SPK_12a SPK_N12 0 0.135976634p
C_SPK_12b SPK_N4 0 0.135976634p
R_SPK_13 SPK_N17 SPK_M12 0.00140596175
L_SPK_13 SPK_M12 SPK_N16 1.305n
C_SPK_13a SPK_N17 0 0.10875p
C_SPK_13b SPK_N16 0 0.10875p
R_SPK_14 SPK_N18 SPK_M13 0.00100562627
L_SPK_14 SPK_M13 SPK_N9 2.4891n
C_SPK_14a SPK_N18 0 0.207425p
C_SPK_14b SPK_N9 0 0.207425p
R_SPK_15 SPK_N8 SPK_M14 0.00114637519
L_SPK_15 SPK_M14 SPK_N17 1.06405428n
C_SPK_15a SPK_N8 0 0.0886711904p
C_SPK_15b SPK_N17 0 0.0886711904p
R_SPK_16 SPK_N6 SPK_M15 0.000417035115
L_SPK_16 SPK_M15 SPK_N2 1.03223448n
C_SPK_16a SPK_N6 0 0.0860195399p
C_SPK_16b SPK_N2 0 0.0860195399p
R_SPK_17 SPK_N10 SPK_M16 0.00154808163
L_SPK_17 SPK_M16 SPK_N13 1.6764n
C_SPK_17a SPK_N10 0 0.1397p
C_SPK_17b SPK_N13 0 0.1397p
R_SPK_18 SPK_N19 SPK_M17 0.000844408163
L_SPK_18 SPK_M17 SPK_N4 0.9144n
C_SPK_18a SPK_N19 0 0.0762p
C_SPK_18b SPK_N4 0 0.0762p
R_SPK_19 SPK_N20 SPK_M18 0.00670077066
L_SPK_19 SPK_M18 SPK_N19 7.25618837n
C_SPK_19a SPK_N20 0 0.604682364p
C_SPK_19b SPK_N19 0 0.604682364p
R_SPK_20 SPK_N10 SPK_M19 0.00136025068
L_SPK_20 SPK_M19 SPK_N20 1.473n
C_SPK_20a SPK_N10 0 0.12275p
C_SPK_20b SPK_N20 0 0.12275p
RPAD_SPK_D3_2_0 SPK_PAD_D3_2 SPK_N9 1m
RPAD_SPK_D3_2_1 SPK_PAD_D3_2 SPK_N10 1m
RPAD_SPK_D3_2_2 SPK_PAD_D3_2 SPK_N20 1m
RPAD_SPK_TP1_1_0 SPK_PAD_TP1_1 SPK_N3 1m
RPAD_SPK_J4_1_0 SPK_PAD_J4_1 SPK_N0 1m
RPAD_SPK_J4_1_1 SPK_PAD_J4_1 SPK_N1 1m
RPAD_SPK_R6_1_0 SPK_PAD_R6_1 SPK_N15 1m
RPAD_SPK_RSH2_2_0 SPK_PAD_RSH2_2 SPK_N11 1m
RPAD_SPK_RSH2_2_1 SPK_PAD_RSH2_2 SPK_N12 1m
RPAD_SPK_RSH2_2_2 SPK_PAD_RSH2_2 SPK_N19 1m
RPAD_SPK_R25_1_0 SPK_PAD_R25_1 SPK_N5 1m
RPAD_SPK_R25_1_1 SPK_PAD_R25_1 SPK_N16 1m
RPAD_SPK_R25_1_2 SPK_PAD_R25_1 SPK_N17 1m
RPAD_SPK_D4_1_0 SPK_PAD_D4_1 SPK_N18 1m
RG_SPK_0 SPK_N0 0 1e12
RG_SPK_1 SPK_N1 0 1e12
RG_SPK_2 SPK_N2 0 1e12
RG_SPK_3 SPK_N3 0 1e12
RG_SPK_4 SPK_N4 0 1e12
RG_SPK_5 SPK_N5 0 1e12
RG_SPK_6 SPK_N6 0 1e12
RG_SPK_7 SPK_N7 0 1e12
RG_SPK_8 SPK_N8 0 1e12
RG_SPK_9 SPK_N9 0 1e12
RG_SPK_10 SPK_N10 0 1e12
RG_SPK_11 SPK_N11 0 1e12
RG_SPK_12 SPK_N12 0 1e12
RG_SPK_13 SPK_N13 0 1e12
RG_SPK_14 SPK_N14 0 1e12
RG_SPK_15 SPK_N15 0 1e12
RG_SPK_16 SPK_N16 0 1e12
RG_SPK_17 SPK_N17 0 1e12
RG_SPK_18 SPK_N18 0 1e12
RG_SPK_19 SPK_N19 0 1e12
RG_SPK_20 SPK_N20 0 1e12
V_ANA_P_SRC ANA_P_SRC 0 10
RFB_ANA_P ANA_P_PAD_FB1_2 ANA_P_FBM 0.25
LFB_ANA_P ANA_P_FBM ANA_P_SRC 240n
RC15 ANA_P_PAD_C15_1 C15_E 0.035
LC15 C15_E C15_L 1.4n
CC15 C15_L 0 1e-07
RC11 ANA_P_PAD_C11_1 C11_E 0.025
LC11 C11_E C11_L 1.4n
CC11 C11_L 0 1e-06
RC9 ANA_P_PAD_C9_1 C9_E 0.035
LC9 C9_E C9_L 1.4n
CC9 C9_L 0 1e-07
V_ANA_N_SRC ANA_N_SRC 0 -10
RFB_ANA_N ANA_N_PAD_FB2_2 ANA_N_FBM 0.25
LFB_ANA_N ANA_N_FBM ANA_N_SRC 240n
RC16 ANA_N_PAD_C16_1 C16_E 0.035
LC16 C16_E C16_L 1.4n
CC16 C16_L 0 1e-07
RC10 ANA_N_PAD_C10_1 C10_E 0.035
LC10 C10_E C10_L 1.4n
CC10 C10_L 0 1e-07
RC12 ANA_N_PAD_C12_1 C12_E 0.025
LC12 C12_E C12_L 1.4n
CC12 C12_L 0 1e-06
VVSENSE VSENSE 0 0
R13 U4AN 0 1k
R14 ISIG U4AN 49.9k
XU4A VSENSE U4AN ANA_P_PAD_U4_8 ANA_N_PAD_U4_4 ISIG OPA1656
RISIG ISIG 0 100k
VVK VK 0 0
VZ ADZ 0 0
XU2 ISIG 0 VK 0 ANA_N_PAD_U2_3 ADZ MUL_RAW_PAD_U2_5 ANA_P_PAD_U2_6 AD633
XU4B MUL_RAW_PAD_U4_5 U4B_N_PAD_U4_6 ANA_P_PAD_U4_8 ANA_N_PAD_U4_4 U4OUT OPA1656
VTEST FB_BREAK U4OUT DC 0 AC 1
RBRK FB_BREAK VCMD_PAD_U4_7 1m
R15 U4B_N_PAD_R15_1 0 1k
R16 VCMD_PAD_R16_1 U4B_N_PAD_R16_2 39k
CPAR_C14 VCMD_PAD_C14_1 U4B_N_PAD_C14_2 0.05p
CPAR_C37 VCMD_PAD_C37_1 U4B_N_PAD_C37_2 0.05p
CPAR_C38 VCMD_PAD_C38_1 U4B_N_PAD_C38_2 0.05p
CPAR_C39 VCMD_PAD_C39_1 U4B_N_PAD_C39_2 0.05p
CPAR_C40 VCMD_PAD_C40_1 U4B_N_PAD_C40_2 0.05p
CPAR_C41 VCMD_PAD_C41_1 U4B_N_PAD_C41_2 0.05p
R5 VCMD_PAD_R5_1 OPA_IN_P_PAD_R5_2 100
R6 SPK_PAD_R6_1 OPA_IN_N_PAD_R6_2 1m
R46 OPA_OUT_PAD_R46_1 DRV_PAD_R46_2 1m
RSH2 DRV_PAD_RSH2_1 SPK_PAD_RSH2_2 .1
R12 DRV_PAD_R12_1 SN 4.7
C4 SN 0 47n
VPWRP PWR_P 0 5
VPWRN PWR_N 0 -5
VESB ESB PWR_N 0.6
RESB ES ESB 1000.0
R10 ES PWR_N 100k
CTLP ES PWR_P 10p
R7 IL PWR_N 57.6k
XU1 OPA_IN_P_PAD_U1_1 OPA_IN_N_PAD_U1_2 IL PWR_N PWR_P OPA_OUT_PAD_U1_6 ES OPA548
C5 PWR_P 0 470u
C6 PWR_N 0 470u
.model D5A D(IS=1e-8 N=1.05 RS=.03 CJO=200p BV=60 IBV=1m TT=20n)
D1 DRV_PAD_D1_2 PWR_P D5A
D2 PWR_N DRV_PAD_D2_1 D5A
.ac dec 180 10 50Meg
.control
run
let lg=-v(U4OUT)/v(FB_BREAK)
wrdata results/full_extracted_loop.dat frequency lg
quit
.endc
.end
